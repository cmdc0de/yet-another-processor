Power rails VIN 5.0 V, AP2112M-3.3TRG1 to VDD, VSS 0
* CPU core, SRAM/bus, and MCU I/O use VDD (not VIN)
* AP2112M-3.3TRG1: CIN=COUT=1uF, EN to VIN
.include reg33.subckt
* VIN is 5.0 V system input; VSS is 0 (SPICE node 0)
VIN vin 0 DC 5.0
Xreg vin vdd 0 REG33
CIN vin 0 1u
COUT vdd 0 1u
Rload vdd 0 1k
.control
set filetype=ascii
op
print v(vdd)
print v(vin)
.endc
.end
