YAP flags slice PHYSICAL-CPU-005
.include ../../lt-spice/yap_cells.lib
VDD VDD 0 DC 3.3
VVSS VSS 0 DC 0
* WE is LATCH EN (active-high load)
Vwe WE 0 PWL(0 3.3 100u 3.3 102u 0 200u 0 202u 3.3 250u 3.3 252u 0 400u 0)
Vd D 0 PWL(0 0 50u 0 52u 3.3 120u 3.3 122u 0 270u 0 272u 3.3 400u 3.3)
X1 D WE Q VDD VSS LATCH
CL Q 0 5p
.tran 1u 400u
.control
set filetype=ascii
run
meas tran qfollow0 FIND v(Q) AT=40u
meas tran qfollow1 FIND v(Q) AT=90u
meas tran qhold1 FIND v(Q) AT=180u
meas tran qfollow0b FIND v(Q) AT=240u
meas tran qhold0 FIND v(Q) AT=330u
.endc
.end
