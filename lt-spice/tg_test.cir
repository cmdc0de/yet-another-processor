TG test CELL-010
.include yap_cells.lib
VDD vdd 0 DC 3.3
Ven en 0 DC 3.3
Vin in 0 DC 0
X1 in out en vdd 0 TG
CL out 0 5p
Rwk out mid 1Meg
Vmid mid 0 DC 1.65
.control
set filetype=ascii
op
print v(out)
alter Vin = 3.3
op
print v(out)
alter Ven = 0
alter Vin = 3.3
op
print v(out)
alter Ven = 0
alter Vin = 0
op
print v(out)
.endc
.end
